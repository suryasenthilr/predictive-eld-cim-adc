* 02_Predictive_LookAhead_Stabilized_Modulator.cir
* Continuous-Time Delta-Sigma Modulator with 3-Bit Flash Quantization, Local Resonator Feedback, and Predictive ELD Compensation
* Clock: 1.0 GHz (Ts = 1.0 ns), Excess Loop Delay: tau_d = 1.3 ns
.options method=gear plotwinsize=0

* Master Clock: 1.0 GHz, 50% duty cycle
Vclk clk 0 PULSE(0 1 0 20p 20p 480p 1n)

* Input Signal: 25uA DC + 15uA AC (31.25 MHz)
Iin 0 vbl SINE(25u 15u 31.25MEG)

* First Integrator: Parasitic Bitline Capacitance C_BL = 100 fF
Cbl vbl 0 100f IC=0.25
Rbl vbl 0 500k

* Local Resonator Feedback: removed to maintain negative loop feedback

* 3-Bit Current-Steering DAC (50 uA full scale, multi-level in [-1, +1])
Bidac vbl 0 I = 50u * ( (V(y_del) + 1.0) / 2.0 )

* Second Integrator: gm = 100uS, C2 = 400fF
Gota 0 v2 vbl ref 100u
Vref ref 0 0.25
C2 v2 0 400f IC=0
Rleak2 v2 0 10MEG

* Predictive Shift Register Taps
Ttap1 y_out 0 y_d1 0 Z0=1k Td=1.0n
Rterm1 y_d1 0 1k

Ttap2 y_out 0 y_d2 0 Z0=1k Td=2.0n
Rterm2 y_d2 0 1k

* Excess Loop Delay: tau_d = 1.3 ns
Teld y_out 0 y_del 0 Z0=1k Td=1.3n
Rterm3 y_del 0 1k

* Predictive Look-Ahead Compensation Network (d1 = 0.7800, d2 = 0.2711)
Bpred v_comp 0 V = 0.7800 * V(y_d1) + 0.2711 * V(y_d2)

* Summing Junction
Bvq vq 0 V = 1.864 * (V(vbl) - 0.25) + 1.520 * V(v2) - V(v_comp)

* 3-Bit Flash Quantizer (8 linear quantization bins from -1.0 to +1.0)
Byout y_out 0 V = table(V(vq), -0.857, -1.0, -0.571, -0.714, -0.286, -0.429, 0.0, -0.143, 0.286, 0.143, 0.571, 0.429, 0.857, 0.714, 1.0, 1.0)

.tran 0 50n 0 5p uic
.save V(clk) V(vbl) V(v2) V(vq) V(v_comp) V(y_out) V(y_del)
.end
