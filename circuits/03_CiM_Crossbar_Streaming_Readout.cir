* 03_CiM_Crossbar_Streaming_Readout.cir
* Compute-in-Memory (CiM) 4-Row Neural Crossbar with Streaming Predictive Delta-Sigma Readout
* Real-time zero-reset MAC dot-product digitization across consecutive inference phases
.options method=gear plotwinsize=0

* Master Clock: 1.0 GHz (Ts = 1.0 ns)
Vclk clk 0 PULSE(0 1 0 20p 20p 480p 1n)

* ===== 4-ROW NEURAL CROSSBAR SYNAPSE ARRAY =====
* Synapse Conductances:
* W1 = 10uS
* W2 = 20uS
* W3 = 15uS
* W4 = 5uS

* Wordline Activation Signals (Voltage levels: 0V = OFF, 1.0V = ON)
* Phase 1 (0 to 25ns): Vector A = [1, 0, 1, 0] -> Expected IMAC = 10u + 15u = 25uA (50% of 50uA DAC)
* Phase 2 (25 to 50ns): Vector A = [1, 1, 1, 0] -> Expected IMAC = 10u + 20u + 15u = 45uA (90% of 50uA DAC)
Vwl1 wl1 0 PULSE(1 1 0 10p 10p 50n 50n)
Vwl2 wl2 0 PULSE(0 1 25n 50p 50p 25n 50n)
Vwl3 wl3 0 PULSE(1 1 0 10p 10p 50n 50n)
Vwl4 wl4 0 PULSE(0 0 0 10p 10p 50n 50n)

* Synaptic Unit Cells driving the shared column Bitline (VBL):
Gcell1 0 vbl wl1 0 10u
Gcell2 0 vbl wl2 0 20u
Gcell3 0 vbl wl3 0 15u
Gcell4 0 vbl wl4 0 5u

* Column Bitline Parasitic Capacitance (Integrator 1): CBL = 100 fF
Cbl vbl 0 100f IC=0.25
Rbl vbl 0 500k

* Feedback Current DAC: 50uA full-scale, switched by delayed bitstream (tau_d = 1.3 ns)
Bidac vbl 0 I = 50u * (1 / (1 + exp(-40 * (V(y_del) - 0.5))))

* Second Integrator: gm = 100uS, C2 = 400fF
Gota 0 v2 vbl ref 100u
Vref ref 0 0.25
C2 v2 0 400f IC=0
Rleak2 v2 0 10MEG

* Predictive Shift Register Taps
Ttap1 y_out 0 y_d1 0 Z0=1k Td=1.0n
Rterm1 y_d1 0 1k

Ttap2 y_out 0 y_d2 0 Z0=1k Td=2.0n
Rterm2 y_d2 0 1k

* Excess Loop Delay: tau_d = 1.3 ns
Teld y_out 0 y_del 0 Z0=1k Td=1.3n
Rterm3 y_del 0 1k

* Predictive Compensation Network (d1 = 0.7800, d2 = 0.2711)
Bpred v_comp 0 V = 0.7800 * (2*V(y_d1) - 1.0) + 0.2711 * (2*V(y_d2) - 1.0)

* Quantizer Summing Node
Bvq vq 0 V = 1.864 * (V(vbl) - 0.25) + 1.520 * V(v2) - V(v_comp)

* Quantizer Latch
Acomp vq 0 clk 0 0 0 y_raw 0 SCHMITT vt=0 vh=1m
Byout y_out 0 V = (V(y_raw) > 0.5)

* Streaming Decimation Filter: tau = R*C = 1k * 3.3p = 3.3 ns (settles within 10-15 ns)
Rfilt y_out y_filt 1k
Cfilt y_filt 0 3.3p IC=0.5

* Transient Simulation for 60 ns
.tran 0 60n 0 5p uic
.save V(clk) V(wl1) V(wl2) V(vbl) V(v2) V(vq) V(y_out) V(y_filt)
.end
